* Active low-pass: non-inverting op-amp, gain 11, fc ~ 1 kHz
* Matches examples/active_lowpass.asc

Vin in 0 DC 0 AC 1 SINE(0 0.1 1k)
Vcc vcc 0 DC 15
Vee vee 0 DC -15

* Feedback network: gain = 1 + Rf/Rg, rolled off by C1 across Rf
Rf minus out 100k
Rg minus 0 10k
C1 minus out 1.6n

XU1 in minus vcc vee out OP07

* Single-pole op-amp macromodel: 120 dB open-loop gain, 0.6 MHz GBW
.subckt OP07 plus minus vcc vee out
Rin plus minus 20meg
Egain gain 0 plus minus 1meg
Rp gain pole 1k
Cp pole 0 265n
Eout outi 0 pole 0 1
Rout outi out 60
.ends OP07

.control
op
ac dec 200 10 1meg
print vdb(out)
.endc

.end
