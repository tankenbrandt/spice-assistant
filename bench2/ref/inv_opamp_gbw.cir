* Inverting amplifier, |gain| = 20.0k/1.00k = 20, around a single-pole op-amp
* written at top level (no .subckt): A0 = 1e5, dominant pole ~20 Hz, GBW ~2 MHz,
* so the closed-loop bandwidth is ~95 kHz.
Vin in 0 DC 0 AC 1
R1 in inv 1k
R2 inv out 20k
Gop 0 p 0 inv 1
Rp p 0 7.87k
Cp p 0 1u
Eout out 0 p 0 12.7
.end
