High-pass RC filter, -3dB cutoff at 2kHz
Vin in 0 AC 1
C1 in out 10n
R1 out 0 7957.75

.control
ac dec 100 1 1meg
print vdb(out)
.endc

.end
