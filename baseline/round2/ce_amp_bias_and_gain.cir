* Common-Emitter BJT Amplifier: Vce=6V, Av=-80, Vcc=12V

Vcc vcc 0 DC 12
Vin in 0 DC 0 AC 1

R1 vcc base 68k
R2 base 0 47k
Rc vcc coll 2.2k
Re emit 0 4.3k

Cin in base 10u
Cout coll out 10u
Ce emit 0 100u

Q1 coll base emit 0 QNPN

.model QNPN NPN(BF=100 IS=1e-14 VAF=100)

.control
op
print v(coll) v(emit) v(base) v(vcc)
print vce = v(coll)-v(emit)

ac dec 10 1 1meg
print vdb(out)
print v(out)/v(in)

let gain_check = v(out)/v(in)
print gain_check

.endc

.end
