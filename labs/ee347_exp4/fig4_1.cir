NMOS 2-1 MUX plus buffer -- EE 347 Exp. 4, Figure 4.1
* X = A'B + AC through two NMOS pass transistors (CD4007, body at ground);
* Y = X' through a 4001B gate wired as an inverting buffer. VDD = 8 V.
VDD vdd 0 DC 8
* A: 0-8 V square, 1 kHz (low for the first half of each period)
Va a 0 PULSE(0 8 0.5m 1u 1u 0.499m 1m)
* B, C: case 1 (B = 8 V, C = 0 V), then case 2 (B = 0 V, C = 8 V) from 1.05 ms --
* switched by hand at the bench, so not on an edge of A (that only adds a glitch).
Vb b 0 PWL(0 8 1.049m 8 1.05m 0)
Vc c 0 PWL(0 0 1.049m 0 1.05m 8)
* A-bar from one 4001B gate wired as an inverter
XU1 a a abar vdd 0 CD4001B
* NMOS pass transistors: B passes when A' is high, C when A is high
Mb x abar b 0 NM W=30u L=5u
Mc x a c 0 NM W=30u L=5u
XU2 x x y vdd 0 CD4001B
* --- Transistor models (shared by every figure in this lab) -------------------
* Level 1 with TOX = 0.1 um, as the handout specifies (EE 347 Exp. 3/4). The
* handouts give no threshold or body-effect values; VTO = +/-1.5 V, GAMMA,
* PHI, LAMBDA and the overlap/junction capacitances (CGSO, CGDO, CBD, CBS)
* below are ASSUMED typical metal-gate CD4000-series values. Without some
* capacitance a node between two off transistors is singular in transient.
.model NM NMOS (LEVEL=1 TOX=0.1u VTO=1.5 GAMMA=0.8 PHI=0.6 LAMBDA=0.02 UO=600
+ CGSO=3e-10 CGDO=3e-10 CBD=20f CBS=20f)
.model PM PMOS (LEVEL=1 TOX=0.1u VTO=-1.5 GAMMA=0.6 PHI=0.6 LAMBDA=0.02 UO=250
+ CGSO=3e-10 CGDO=3e-10 CBD=20f CBS=20f)
* --- CD4001B: one double-buffered 2-input NOR, W/L from Exp. 3 Figure 3.4 -----
.subckt CD4001B a b j vdd vss
Mp1 n1 a vdd vdd PM W=50u L=5u
Mp2 nor b n1 vdd PM W=50u L=5u
Mn1 nor a vss vss NM W=10u L=5u
Mn2 nor b vss vss NM W=10u L=5u
Mp3 inv1 nor vdd vdd PM W=100u L=5u
Mn3 inv1 nor vss vss NM W=40u L=5u
Mp4 j inv1 vdd vdd PM W=250u L=5u
Mn4 j inv1 vss vss NM W=100u L=5u
.ends CD4001B
* CD4007 discrete transistors: size ASSUMED (the handouts give none).
* NMOS W/L = 30/5, PMOS W/L = 60/5.
* Gear integration: trapezoidal stalls ("timestep too small") on the level-1
* gate capacitances when two inputs switch at the same instant.
.options method=gear
.control
tran 2u 2m
.endc
.end
