Two-stage dynamic CMOS shift register in its test setup -- EE 347 Exp. 5, Figures 5.2 and 5.3
* Figure 5.2's two stages inside Figure 5.3's loop: the pulse generator drives
* two 7400 gates (each wired as an inverter) that make phi and phibar, and a
* third 7400 gate feeds VOUT back, inverted, to VIN. VDD = VCC = 5 V.
* Nodes: in = node (1) = VIN, n2 = node (2) between the stages, out = node (3) = VOUT.
VDD vdd 0 DC 5
* Pulse generator: 0-5 V square wave, 1 kHz, 1 ns edges. It is high for the
* first half period, so phi (its inverse) starts low.
Vgen gen 0 PULSE(5 0 0.5m 1n 1n 0.499999m 1m)
* Clock buffers, Figure 5.3: phi = NOT gen, phibar = NOT phi (1/4 7400 each)
XU1 gen gen phi vdd 0 NAND74HC00
XU2 phi phi phib vdd 0 NAND74HC00
* --- Stage 1 (Figure 5.1): TG(phi), inverter, TG(phibar), inverter ---------
XTG1 in x1 phi vdd 0 CD4016
M1P y1 x1 vdd vdd PM W=60u L=5u
M1N y1 x1 0 0 NM W=30u L=5u
XTG2 y1 x2 phib vdd 0 CD4016
M2P n2 x2 vdd vdd PM W=60u L=5u
M2N n2 x2 0 0 NM W=30u L=5u
* --- Stage 2: the same, clocked the same way (Figure 5.2) ------------------
XTG3 n2 x3 phi vdd 0 CD4016
M3P y3 x3 vdd vdd PM W=60u L=5u
M3N y3 x3 0 0 NM W=30u L=5u
XTG4 y3 x4 phib vdd 0 CD4016
M4P out x4 vdd vdd PM W=60u L=5u
M4N out x4 0 0 NM W=30u L=5u
* Feedback, Figure 5.3: VIN = NOT VOUT (1/4 7400, inputs tied)
XU3 out out in vdd 0 NAND74HC00
* "Assuming initially that the input has been low for a long period of time":
* every stored node holds what a long-low input leaves behind.
.ic v(in)=0 v(x1)=0 v(y1)=5 v(x2)=5 v(n2)=0 v(x3)=0 v(y3)=5 v(x4)=5 v(out)=0
* --- Models (shared by both figures in this lab) ----------------------------
* Level 1 with TOX = 0.1 um and the same ASSUMED threshold, body-effect and
* capacitance values as the Exp. 3 and Exp. 4 pre-labs; this handout gives no
* transistor data at all.
.model NM NMOS (LEVEL=1 TOX=0.1u VTO=1.5 GAMMA=0.8 PHI=0.6 LAMBDA=0.02 UO=600
+ CGSO=3e-10 CGDO=3e-10 CBD=20f CBS=20f)
.model PM PMOS (LEVEL=1 TOX=0.1u VTO=-1.5 GAMMA=0.6 PHI=0.6 LAMBDA=0.02 UO=250
+ CGSO=3e-10 CGDO=3e-10 CBD=20f CBS=20f)
* --- CD4016: one transmission gate (Figure 5.4) -----------------------------
* One non-inverting control pin; the chip makes the complementary control
* internally (handout p. 5-2), modelled here as an inverter. Sizes ASSUMED.
.subckt CD4016 a b ctl vdd vss
MTGCP ctlb ctl vdd vdd PM W=60u L=5u
MTGCN ctlb ctl vss vss NM W=30u L=5u
MTGN a ctl b vss NM W=30u L=5u
MTGP a ctlb b vdd PM W=60u L=5u
.ends CD4016
* --- 7400-family 2-input NAND (Figure 5.5), modelled as CMOS (74HC00) ------
* ASSUMED: the 74HC00 is one of the three parts Figure 5.5 names; a TTL 7400
* has the same logic but a weaker high level (the handout's pull-up note).
.subckt NAND74HC00 a b y vdd vss
MNDPA y a vdd vdd PM W=60u L=5u
MNDPB y b vdd vdd PM W=60u L=5u
MNDNA y a nd1 vss NM W=60u L=5u
MNDNB nd1 b vss vss NM W=60u L=5u
.ends NAND74HC00
* CD4007 discrete transistors: size ASSUMED as in Exp. 3/4 (N 30/5, P 60/5).
.options method=gear
.control
tran 2u 12.25m
.endc
.end
